** _uc85df277e575358def4e8c96364f4e901a **
*
* NI Multisim to SPICE Netlist Export
* Generated by: zhaijiayu
* Thu, Jul 09, 2026 14:10:47
*

*## Multisim Component V1 ##*
vV1 Uin 0 dc 0 ac 1 0
+      distof1 0 0
+      distof2 0 0
+      sin(0 1 1000 0 0 0)

*## Multisim Component VEE ##*
VEEVEE  VEE 0 dc -12

*## Multisim Component VCC ##*
VCCVCC  VCC 0 dc 12

*## Multisim Component C2 ##*
cC2 1 0 1e-08

*## Multisim Component C1 ##*
cC1 1 3 1e-08

*## Multisim Component R4 ##*
rR4 4 0 5000 vresR4
.model vresR4 r(  )

*## Multisim Component R3 ##*
rR3 1 2 3900 vresR3
.model vresR3 r(  )

*## Multisim Component R2 ##*
rR2 4 Uout 20000 vresR2
.model vresR2 r(  )

*## Multisim Component R1 ##*
rR1 Uin 1 27000 vresR1
.model vresR1 r(  )

*## Multisim Component U1 ##*
xU1_B 3 4 VCC VEE Uout TL071__OPAMP__1

*## Multisim Component U1 ##*
xU1_A 2 3 VCC VEE 3 TL071__OPAMP__1

*****************************************************************************
* (C) Copyright 2002 Texas Instruments Incorporated. All rights reserved.
*****************************************************************************
** This model is designed as an aid for customers of Texas Instruments.
** TI and its licensors and suppliers make no warranties, either expressed
** or implied, with respect to this model, including the warranties of
** merchantability or fitness for a particular purpose.  The model is
** provided solely on an as is basis.  The entire risk as to its quality
** and performance is with the customer.
*****************************************************************************
* TL071 OPERATIONAL AMPLIFIER "MACROMODEL" SUBCIRCUIT
* CREATED USING PARTS RELEASE 4.01 ON 06/16/89 AT 13:08
* (REV N/A)      SUPPLY VOLTAGE: +/-15V
* CONNECTIONS:   NON-INVERTING INPUT
*                | INVERTING INPUT
*                | | POSITIVE POWER SUPPLY
*                | | | NEGATIVE POWER SUPPLY
*                | | | | OUTPUT
*                | | | | |
.SUBCKT TL071__OPAMP__1    1 2 3 4 5
*
  C1   11 12 3.498E-12
  C2    6  7 15.00E-12
  DC    5 53 DX
  DE   54  5 DX
  DLP  90 91 DX
  DLN  92 90 DX
  DP    4  3 DX
  EGND 99  0 POLY(2) (3,0) (4,0) 0 .5 .5
  FB    7 99 POLY(5) VB VC VE VLP VLN 0 4.715E6 -5E6 5E6 5E6 -5E6
  GA    6  0 11 12 282.8E-6
  GCM   0  6 10 99 8.942E-9
  ISS   3 10 DC 195.0E-6
  HLIM 90  0 VLIM 1K
  J1   11  2 10 JX
  J2   12  1 10 JX
  R2    6  9 100.0E3
  RD1   4 11 3.536E3
  RD2   4 12 3.536E3
  RO1   8  5 150
  RO2   7 99 150
  RP    3  4 2.143E3
  RSS  10 99 1.026E6
  VB    9  0 DC 0
  VC    3 53 DC 2.200
  VE   54  4 DC 2.200
  VLIM  7  8 DC 0
  VLP  91  0 DC 25
  VLN   0 92 DC 25
.MODEL DX D(IS=800.0E-18)
.MODEL JX PJF(IS=15.00E-12 BETA=270.1E-6 VTO=-1)
.ENDS
